// ============================================================
// Behavioral LDO model for Cadence Spectre  (auto-gen: harness/fit_model.py)
// Equivalent to model/ldo_model.lib (validated in ngspice). NO laplace_nd.
//   Zout = (R_a + sL_a||R_pl) || (R_b+sL_b) || (ESR+1/sCout) ; R_pl damps L
//   PSRR = i_c*Zout, i_c = G0 + sum Gi/(1+s/wi) [real bank] + one signed COMPLEX 2nd-
//          order section (b0+b1 s)/(1+s/(Q w0)+(s/w0)^2) -> non-min-phase / notch PHASE
//          (V4/V3). LP filter resistors are noiseless conductances (no thermal noise).
//   Noise= DECOUPLED Norton @vout: white-R + 6 R||C-Lorentzian current sections,
//          transconducted into vout (gm sets amplitude) -> In*|Zout| = Sv. pnoise/hbnoise.
//   slew_en=1 : nonlinear DC-curve branch (current-limit + dropout), INLINE PWL
// Ports: vin vout gnd (explicit ground -- no global-ground references inside).
// Instance params: iload, slew_en, vdd (supply DC ref + dc_linereg Vout tracking),
//   voutdc (>0 pins Vout DC; 0 = characterized). Defaults = characterized behavior.
// Params interpolated as quadratics in ln(iload) through corners {20u,121u,250u}.
// ============================================================
`include "constants.vams"
`include "disciplines.vams"

module ldo_model(vin, vout, gnd);
  inout vin, vout, gnd;
  electrical vin, vout, gnd, vrg, nA, nC, nbb, np1, np2, np3, vrf, ncs1, ncs2, nw, nk1, nk2, nk3, nk4, nk5, nk6;

  parameter real iload   = 1.210000e-04 from (0:inf);
  parameter integer slew_en = 0 from [0:1];
  parameter real vdd    = 1.05;   // supply DC operating point [V]: PSRR DC reference
                                    // + dc_linereg Vout-DC tracking (clamped to the
                                    // characterized span [0.9,1.3]V)
  parameter real voutdc = 0 from [0:inf);   // >0: pin Vout DC at this iload [V]
                                            // (0 = characterized DC; small-signal unchanged)
  parameter real Cout = 9.969315e-10;   // auto-extracted physical output cap
  parameter real ESR  = 5.000093e-01;   // auto-extracted physical ESR
  parameter real VREG121 = 9.011242e-01;
  parameter real NRk = 1.000000e+06;   // fixed noise-section resistor (gm sets amplitude)
  parameter real Cn1 = 8.588995e-09;   // corner 18.53 Hz
  parameter real Cn2 = 6.072694e-10;   // corner 262.1 Hz
  parameter real Cn3 = 4.191329e-11;   // corner 3797 Hz
  parameter real Cn4 = 4.053907e-13;   // corner 3.926e+05 Hz
  parameter real Cn5 = 2.027003e-13;   // corner 7.852e+05 Hz
  parameter real Cn6 = 2.090802e-15;   // corner 7.612e+07 Hz

  real u, ic, R_a, L_a, R_pl, R_b, L_b, G0, G1, w1, G2, w2, G3, w3, gnw, gn1, gn2, gn3, gn4, gn5, gn6, sa1, sa2, sa3, vreg, Cps;
  real pcb0, pcb1, pcw0, pcq, pca1, pca2, Rpc, Lpc, Cpc, gqb1;
  real vddc, lrsh, vregeff, vdrp;

  analog begin
    @(initial_step) begin
      ic = min(max(iload, 2.000000e-05), 2.500000e-04);
      u  = ln(ic);
      R_a = min(max(exp((1.836710e-01)*u*u + (2.900097e+00)*u + (1.429951e+01)),1.774208e+01),8.376544e+01);
      L_a = min(max(exp((1.396641e-01)*u*u + (2.061160e+00)*u + (-4.541689e+00)),5.936622e-06),2.787298e-05);
      R_pl = min(max(exp((2.332657e-13)*u*u + (4.518403e-12)*u + (2.072327e+01)),9.950249e+08),1.005000e+09);
      R_b = min(max(exp((1.392200e-16)*u*u + (4.129372e-15)*u + (2.072327e+01)),9.950249e+08),1.005000e+09);
      L_b = min(max(exp((6.069877e-16)*u*u + (6.085391e-15)*u + (-2.763102e+01)),9.950249e-13),1.005000e-12);
      G0 = min(max((1.955015e-04)*u*u + (4.609397e-03)*u + (2.746233e-02),4.655433e-04),2.691572e-03);
      G1 = min(max((4.386092e-05)*u*u + (2.757975e-04)*u + (-2.593843e-03),-1.871177e-03),-4.361133e-04);
      w1 = min(max(exp((3.844910e-02)*u*u + (7.335623e-01)*u + (1.840398e+01)),2.989163e+06),3.182342e+06);
      G2 = min(max((0.000000e+00)*u*u + (0.000000e+00)*u + (0.000000e+00),0.000000e+00),0.000000e+00);
      w2 = min(max(exp((1.392200e-16)*u*u + (4.129372e-15)*u + (2.072327e+01)),9.950249e+08),1.005000e+09);
      G3 = min(max((0.000000e+00)*u*u + (0.000000e+00)*u + (0.000000e+00),0.000000e+00),0.000000e+00);
      w3 = min(max(exp((1.392200e-16)*u*u + (4.129372e-15)*u + (2.072327e+01)),9.950249e+08),1.005000e+09);
      pcb0 = min(max((0.000000e+00)*u*u + (0.000000e+00)*u + (0.000000e+00),0.000000e+00),0.000000e+00);
      pcb1 = min(max((0.000000e+00)*u*u + (0.000000e+00)*u + (0.000000e+00),0.000000e+00),0.000000e+00);
      pcw0 = min(max(exp((4.717895e-16)*u*u + (1.054077e-14)*u + (1.219951e+01)),1.977032e+05),1.996852e+05);
      pcq = min(max(exp((0.000000e+00)*u*u + (0.000000e+00)*u + (0.000000e+00)),9.950249e-01),1.005000e+00);
      gnw = min(max(exp((-5.816257e-02)*u*u + (-1.163303e+00)*u + (-1.419655e+01)),1.927479e-04),2.217763e-04);
      gn1 = min(max(exp((-1.880571e-01)*u*u + (-2.987837e+00)*u + (-1.143675e+01)),3.232263e-01),1.511066e+00);
      gn2 = min(max(exp((-1.836635e-01)*u*u + (-2.904064e+00)*u + (-1.244267e+01)),7.986837e-02),3.731874e-01);
      gn3 = min(max(exp((-2.029024e-01)*u*u + (-3.270874e+00)*u + (-1.545121e+01)),2.194172e-02),1.027614e-01);
      gn4 = min(max(exp((-1.691179e-01)*u*u + (-2.625159e+00)*u + (-1.304568e+01)),1.173413e-02),5.495036e-02);
      gn5 = min(max(exp((2.098653e+00)*u*u + (3.828265e+01)*u + (1.616939e+02)),2.565785e-06),1.084506e-03);
      gn6 = min(max(exp((-8.941417e-02)*u*u + (-1.873140e+00)*u + (-2.762052e+01)),1.197424e-08),1.830523e-08);
      sa1 = min(max(exp((-1.441285e-01)*u*u + (-2.163043e+00)*u + (-1.987743e+01)),1.590365e-06),7.161181e-06);
      sa2 = min(max(exp((-1.552560e-01)*u*u + (-2.360956e+00)*u + (-2.223238e+01)),3.491402e-07),1.631908e-06);
      sa3 = min(max(exp((-2.317441e-03)*u*u + (-4.557877e-02)*u + (-1.224836e+01)),5.934466e-06),6.017734e-06);
      vreg = min(max((2.001640e-04)*u*u + (2.411893e-03)*u + (9.065944e-01),9.003417e-01),9.039489e-01);
      Cps = 1e-12;
      // complex PSRR section: a1=1/(Q.w0), a2=1/w0^2 ; series R-L-C (Cpc fixed)
      Cpc = 1e-12;
      pca1 = 1.0/(pcq*pcw0); pca2 = 1.0/(pcw0*pcw0);
      Rpc = pca1/Cpc; Lpc = pca2/Cpc; gqb1 = pcb1/pca1;
      // R3-L1: vdd line-reg DC shift (characterized dc_linereg poly) / voutdc override
      vddc = min(max(vdd, 9.000000e-01), 1.300000e+00);
      lrsh = (-9.641010e+00)*vddc*vddc*vddc*vddc + (4.378899e+01)*vddc*vddc*vddc + (-7.433767e+01)*vddc*vddc + (5.590457e+01)*vddc + (-1.481593e+01) - (8.991185e-01);
      vregeff = (voutdc > 0) ? voutdc + R_a*ic : vreg + lrsh;
    end

    // ---- references / DC operating point ----
    V(vrf, gnd) <+ vdd;              // supply DC reference (settable; no DC coupling)
    V(vrg, gnd) <+ vregeff;          // regulated output reference (incl. R3-L1 shift)

    // ---- Zout branch C: series Cout + ESR (vout -> vrg) ----
    I(vout, nC) <+ Cout*ddt(V(vout, nC));
    V(nC, vrg)  <+ ESR*I(nC, vrg);

    // ---- Zout branch B: optional 2nd R-L (R_b->inf disables it) ----
    I(vout, nbb) <+ idt(V(vout, nbb))/L_b;
    V(nbb, vrg)  <+ R_b*I(nbb, vrg);

    // ---- Zout branch A: (L_a || R_pl) + (R_a | nonlinear dropout) ----
    // L_a||R_pl as summed current contributions (idt form admits the parallel R)
    I(vout, nA) <+ idt(V(vout, nA))/L_a + V(vout, nA)/R_pl;
    if (slew_en == 0)
      V(nA, vrg) <+ R_a*I(nA, vrg);
    else begin
      // nonlinear DC-curve branch (current-limit + dropout): INLINE closed-form PWL of
      // the characterized (Vdrop, Iload) table -- i = i1 + g1*(v-v1) + sum dg_k*max(v-v_k,0)
      // == 1-D linear table interpolation, linear end extrapolation. Self-contained
      // (no external table file -> no run-dir path issues; OpenVAF-compilable, R8 closed).
      vdrp = V(vrg, nA) - (vregeff - VREG121);
      I(vrg, nA) <+ (1.000000e-06) + (3.394369e-03)*(vdrp-(-5.378096e-03)) + (7.626646e-03)*max(vdrp-(-1.842829e-03),0) + (5.796378e-03)*max(vdrp-(-7.539995e-04),0) + (5.012260e-03)*max(vdrp-(-4.045254e-05),0)
                       + (4.397047e-03)*max(vdrp-(5.092585e-04),0) + (3.883882e-03)*max(vdrp-(9.668075e-04),0) + (3.442807e-03)*max(vdrp-(1.365338e-03),0) + (3.056422e-03)*max(vdrp-(1.722977e-03),0)
                       + (2.712922e-03)*max(vdrp-(2.050758e-03),0) + (2.404498e-03)*max(vdrp-(2.355925e-03),0) + (2.125848e-03)*max(vdrp-(2.643507e-03),0) + (1.873402e-03)*max(vdrp-(2.917148e-03),0)
                       + (1.644435e-03)*max(vdrp-(3.179578e-03),0) + (1.436358e-03)*max(vdrp-(3.432898e-03),0) + (1.247997e-03)*max(vdrp-(3.678763e-03),0) + (1.077317e-03)*max(vdrp-(3.918498e-03),0)
                       + (9.240856e-04)*max(vdrp-(4.153182e-03),0) + (7.853476e-04)*max(vdrp-(4.383700e-03),0) + (6.620508e-04)*max(vdrp-(4.610792e-03),0) + (5.504703e-04)*max(vdrp-(4.835074e-03),0)
                       + (4.515205e-04)*max(vdrp-(5.057072e-03),0) + (3.636230e-04)*max(vdrp-(5.277231e-03),0) + (2.844714e-04)*max(vdrp-(5.495931e-03),0) + (2.145304e-04)*max(vdrp-(5.713503e-03),0)
                       + (1.529394e-04)*max(vdrp-(5.930232e-03),0) + (9.701584e-05)*max(vdrp-(6.146364e-03),0) + (4.876429e-05)*max(vdrp-(6.362119e-03),0) + (4.648678e-06)*max(vdrp-(6.577685e-03),0)
                       + (-3.381432e-05)*max(vdrp-(6.793233e-03),0) + (-6.827758e-05)*max(vdrp-(7.008912e-03),0) + (-9.915410e-05)*max(vdrp-(7.224856e-03),0) + (-1.266369e-04)*max(vdrp-(7.441186e-03),0)
                       + (-1.514570e-04)*max(vdrp-(7.658011e-03),0) + (-1.730909e-04)*max(vdrp-(7.875431e-03),0) + (-1.938098e-04)*max(vdrp-(8.093535e-03),0) + (-2.118436e-04)*max(vdrp-(8.312410e-03),0)
                       + (-2.284586e-04)*max(vdrp-(8.532134e-03),0) + (-2.441486e-04)*max(vdrp-(8.752781e-03),0) + (-2.584238e-04)*max(vdrp-(8.974423e-03),0) + (-2.722601e-04)*max(vdrp-(9.197128e-03),0)
                       + (-2.851670e-04)*max(vdrp-(9.420964e-03),0) + (3.578365e-04)*max(vdrp-(9.645997e-03),0) + (-9.450441e-04)*max(vdrp-(9.795019e-03),0) + (-5.432412e-04)*max(vdrp-(1.017425e-02),0)
                       + (-5.768318e-04)*max(vdrp-(1.055743e-02),0) + (-6.121363e-04)*max(vdrp-(1.094489e-02),0) + (-6.503318e-04)*max(vdrp-(1.133700e-02),0) + (-6.923572e-04)*max(vdrp-(1.173417e-02),0)
                       + (-7.397272e-04)*max(vdrp-(1.213688e-02),0) + (-7.939984e-04)*max(vdrp-(1.254568e-02),0) + (-8.569619e-04)*max(vdrp-(1.296123e-02),0) + (-9.304019e-04)*max(vdrp-(1.338430e-02),0)
                       + (-1.017051e-03)*max(vdrp-(1.381588e-02),0) + (-1.119727e-03)*max(vdrp-(1.425713e-02),0) + (-1.242184e-03)*max(vdrp-(1.470956e-02),0) + (-1.387894e-03)*max(vdrp-(1.517508e-02),0)
                       + (-1.561055e-03)*max(vdrp-(1.565613e-02),0) + (-1.765077e-03)*max(vdrp-(1.615595e-02),0) + (-2.000962e-03)*max(vdrp-(1.667883e-02),0) + (-2.264815e-03)*max(vdrp-(1.723058e-02),0)
                       + (-2.543190e-03)*max(vdrp-(1.781910e-02),0) + (-2.808520e-03)*max(vdrp-(1.845523e-02),0) + (-3.015054e-03)*max(vdrp-(1.915375e-02),0) + (-3.103950e-03)*max(vdrp-(1.993449e-02),0)
                       + (-3.021978e-03)*max(vdrp-(2.082287e-02),0) + (-2.751530e-03)*max(vdrp-(2.184899e-02),0) + (-2.332775e-03)*max(vdrp-(2.304378e-02),0) + (-1.852296e-03)*max(vdrp-(2.443204e-02),0)
                       + (-1.400378e-03)*max(vdrp-(2.602513e-02),0) + (-1.031311e-03)*max(vdrp-(2.781822e-02),0) + (-7.560195e-04)*max(vdrp-(2.979401e-02),0) + (-5.600310e-04)*max(vdrp-(3.192926e-02),0)
                       + (-4.225215e-04)*max(vdrp-(3.420031e-02),0) + (-3.256190e-04)*max(vdrp-(3.658581e-02),0) + (-2.564047e-04)*max(vdrp-(3.906770e-02),0) + (-2.060781e-04)*max(vdrp-(4.163115e-02),0)
                       + (-1.687923e-04)*max(vdrp-(4.426415e-02),0) + (-1.406640e-04)*max(vdrp-(4.695699e-02),0) + (-1.190643e-04)*max(vdrp-(4.970182e-02),0) + (-1.022191e-04)*max(vdrp-(5.249224e-02),0)
                       + (-8.888188e-05)*max(vdrp-(5.532303e-02),0) + (-7.817109e-05)*max(vdrp-(5.818989e-02),0) + (-6.947687e-05)*max(vdrp-(6.108924e-02),0) + (-6.232530e-05)*max(vdrp-(6.401809e-02),0)
                       + (-5.639289e-05)*max(vdrp-(6.697391e-02),0) + (-5.141751e-05)*max(vdrp-(6.995458e-02),0) + (-4.721266e-05)*max(vdrp-(7.295826e-02),0) + (-4.362681e-05)*max(vdrp-(7.598340e-02),0)
                       + (-4.054858e-05)*max(vdrp-(7.902863e-02),0) + (-3.788723e-05)*max(vdrp-(8.209277e-02),0) + (-3.557625e-05)*max(vdrp-(8.517481e-02),0) + (-3.354825e-05)*max(vdrp-(8.827384e-02),0)
                       + (-3.177117e-05)*max(vdrp-(9.138906e-02),0) + (-3.019522e-05)*max(vdrp-(9.451977e-02),0) + (-2.879964e-05)*max(vdrp-(9.766535e-02),0) + (-2.755322e-05)*max(vdrp-(1.008252e-01),0)
                       + (-2.643632e-05)*max(vdrp-(1.039990e-01),0) + (-2.543626e-05)*max(vdrp-(1.071860e-01),0) + (-2.453338e-05)*max(vdrp-(1.103861e-01),0) + (-2.371853e-05)*max(vdrp-(1.135988e-01),0)
                       + (-2.297543e-05)*max(vdrp-(1.168237e-01),0) + (-2.230747e-05)*max(vdrp-(1.200606e-01),0) + (-2.169351e-05)*max(vdrp-(1.233093e-01),0) + (-2.113380e-05)*max(vdrp-(1.265695e-01),0)
                       + (-2.062676e-05)*max(vdrp-(1.298409e-01),0) + (-2.015800e-05)*max(vdrp-(1.331234e-01),0) + (-1.973012e-05)*max(vdrp-(1.364168e-01),0) + (-1.934023e-05)*max(vdrp-(1.397209e-01),0)
                       + (-1.897827e-05)*max(vdrp-(1.430357e-01),0) + (-1.864715e-05)*max(vdrp-(1.463609e-01),0) + (-1.834965e-05)*max(vdrp-(1.496964e-01),0) + (-1.806720e-05)*max(vdrp-(1.530421e-01),0)
                       + (-1.781710e-05)*max(vdrp-(1.563981e-01),0) + (-1.758454e-05)*max(vdrp-(1.597640e-01),0) + (-1.737435e-05)*max(vdrp-(1.631400e-01),0) + (-1.718082e-05)*max(vdrp-(1.665259e-01),0)
                       + (-1.701046e-05)*max(vdrp-(1.699216e-01),0) + (-1.685591e-05)*max(vdrp-(1.733273e-01),0) + (-1.671681e-05)*max(vdrp-(1.767427e-01),0) + (-1.659790e-05)*max(vdrp-(1.801678e-01),0)
                       + (-1.649201e-05)*max(vdrp-(1.836028e-01),0) + (-1.640388e-05)*max(vdrp-(1.870475e-01),0) + (-1.633144e-05)*max(vdrp-(1.905020e-01),0) + (-1.627602e-05)*max(vdrp-(1.939662e-01),0)
                       + (-1.623724e-05)*max(vdrp-(1.974402e-01),0) + (-1.621145e-05)*max(vdrp-(2.009241e-01),0) + (-1.620487e-05)*max(vdrp-(2.044178e-01),0) + (-1.621869e-05)*max(vdrp-(2.079215e-01),0)
                       + (-1.624438e-05)*max(vdrp-(2.114351e-01),0) + (-1.629446e-05)*max(vdrp-(2.149588e-01),0) + (-1.636200e-05)*max(vdrp-(2.184926e-01),0) + (-1.645289e-05)*max(vdrp-(2.220367e-01),0)
                       + (-1.656182e-05)*max(vdrp-(2.255911e-01),0) + (-1.670084e-05)*max(vdrp-(2.291560e-01),0) + (-1.685984e-05)*max(vdrp-(2.327316e-01),0) + (-1.705216e-05)*max(vdrp-(2.363180e-01),0)
                       + (-1.726921e-05)*max(vdrp-(2.399154e-01),0) + (-1.752246e-05)*max(vdrp-(2.435240e-01),0) + (-1.780781e-05)*max(vdrp-(2.471440e-01),0) + (-1.813026e-05)*max(vdrp-(2.507758e-01),0)
                       + (-1.849461e-05)*max(vdrp-(2.544195e-01),0) + (-1.890241e-05)*max(vdrp-(2.580756e-01),0) + (-1.935507e-05)*max(vdrp-(2.617443e-01),0) + (-1.986116e-05)*max(vdrp-(2.654261e-01),0)
                       + (-2.041573e-05)*max(vdrp-(2.691214e-01),0) + (-2.103113e-05)*max(vdrp-(2.728307e-01),0) + (-2.170476e-05)*max(vdrp-(2.765546e-01),0) + (-2.244381e-05)*max(vdrp-(2.802935e-01),0)
                       + (-2.324789e-05)*max(vdrp-(2.840482e-01),0) + (-2.412049e-05)*max(vdrp-(2.878194e-01),0) + (-2.506596e-05)*max(vdrp-(2.916077e-01),0) + (-2.608397e-05)*max(vdrp-(2.954142e-01),0)
                       + (-2.717371e-05)*max(vdrp-(2.992397e-01),0) + (-2.834060e-05)*max(vdrp-(3.030851e-01),0) + (-2.957597e-05)*max(vdrp-(3.069516e-01),0) + (-3.088797e-05)*max(vdrp-(3.108404e-01),0)
                       + (-3.226421e-05)*max(vdrp-(3.147526e-01),0) + (-3.370887e-05)*max(vdrp-(3.186897e-01),0) + (-3.521249e-05)*max(vdrp-(3.226531e-01),0) + (-3.677400e-05)*max(vdrp-(3.266443e-01),0)
                       + (-3.838666e-05)*max(vdrp-(3.306650e-01),0) + (-4.004321e-05)*max(vdrp-(3.347171e-01),0) + (-4.174187e-05)*max(vdrp-(3.388022e-01),0) + (-4.347876e-05)*max(vdrp-(3.429225e-01),0)
                       + (-4.524235e-05)*max(vdrp-(3.470800e-01),0) + (-4.703771e-05)*max(vdrp-(3.512770e-01),0) + (-4.885612e-05)*max(vdrp-(3.555159e-01),0) + (-5.070222e-05)*max(vdrp-(3.597991e-01),0)
                       + (-5.256719e-05)*max(vdrp-(3.641293e-01),0) + (-5.445881e-05)*max(vdrp-(3.685093e-01),0) + (-5.637917e-05)*max(vdrp-(3.729423e-01),0) + (-5.832313e-05)*max(vdrp-(3.774313e-01),0)
                       + (-6.030546e-05)*max(vdrp-(3.819799e-01),0) + (-6.232073e-05)*max(vdrp-(3.865917e-01),0) + (-6.437791e-05)*max(vdrp-(3.912707e-01),0) + (-6.648105e-05)*max(vdrp-(3.960214e-01),0)
                       + (-6.863679e-05)*max(vdrp-(4.008482e-01),0) + (-7.084255e-05)*max(vdrp-(4.057563e-01),0) + (-7.311129e-05)*max(vdrp-(4.107513e-01),0) + (-7.543658e-05)*max(vdrp-(4.158392e-01),0)
                       + (-7.782674e-05)*max(vdrp-(4.210266e-01),0) + (-8.027462e-05)*max(vdrp-(4.263209e-01),0) + (-8.278422e-05)*max(vdrp-(4.317302e-01),0) + (-8.534399e-05)*max(vdrp-(4.372633e-01),0)
                       + (-8.794862e-05)*max(vdrp-(4.429303e-01),0) + (-9.058298e-05)*max(vdrp-(4.487420e-01),0) + (-9.322949e-05)*max(vdrp-(4.547109e-01),0) + (-1.450827e-04)*max(vdrp-(4.608506e-01),0)
                       + (-5.370591e-05)*max(vdrp-(4.672765e-01),0) + (-1.011835e-04)*max(vdrp-(4.738153e-01),0) + (-1.035540e-04)*max(vdrp-(4.805777e-01),0) + (-1.057204e-04)*max(vdrp-(4.875855e-01),0)
                       + (-1.076155e-04)*max(vdrp-(4.948629e-01),0) + (-1.091529e-04)*max(vdrp-(5.024369e-01),0) + (-1.102352e-04)*max(vdrp-(5.103375e-01),0) + (-1.107583e-04)*max(vdrp-(5.185977e-01),0)
                       + (-1.106074e-04)*max(vdrp-(5.272539e-01),0) + (-1.096738e-04)*max(vdrp-(5.363454e-01),0) + (-1.078555e-04)*max(vdrp-(5.459139e-01),0) + (-1.050745e-04)*max(vdrp-(5.560030e-01),0)
                       + (-1.012921e-04)*max(vdrp-(5.666568e-01),0) + (-9.652174e-05)*max(vdrp-(5.779183e-01),0) + (-9.084444e-05)*max(vdrp-(5.898269e-01),0) + (-8.441192e-05)*max(vdrp-(6.024166e-01),0)
                       + (-7.744308e-05)*max(vdrp-(6.157128e-01),0) + (-7.020299e-05)*max(vdrp-(6.297306e-01),0) + (-6.297342e-05)*max(vdrp-(6.444740e-01),0) + (-5.601789e-05)*max(vdrp-(6.599350e-01),0)
                       + (-4.955014e-05)*max(vdrp-(6.760959e-01),0) + (-4.371481e-05)*max(vdrp-(6.929309e-01),0) + (-3.858169e-05)*max(vdrp-(7.104089e-01),0) + (-3.415486e-05)*max(vdrp-(7.284969e-01),0)
                       + (-3.038965e-05)*max(vdrp-(7.471614e-01),0) + (-2.721118e-05)*max(vdrp-(7.663707e-01),0) + (-2.453264e-05)*max(vdrp-(7.860954e-01),0) + (-2.226700e-05)*max(vdrp-(8.063093e-01),0)
                       + (-2.033551e-05)*max(vdrp-(8.269886e-01),0) + (-1.866987e-05)*max(vdrp-(8.481119e-01),0) + (-1.721211e-05)*max(vdrp-(8.696602e-01),0) + (-1.591649e-05)*max(vdrp-(8.916157e-01),0)
                       + (-1.475458e-05)*max(vdrp-(9.139616e-01),0) + (-1.370776e-05)*max(vdrp-(9.366820e-01),0) + (-1.275736e-05)*max(vdrp-(9.597619e-01),0) + (-1.188653e-05)*max(vdrp-(9.831866e-01),0)
                       + (-1.108285e-05)*max(vdrp-(1.006942e+00),0) + (-5.277950e-06)*max(vdrp-(1.031014e+00),0) + (-1.486467e-05)*max(vdrp-(1.055241e+00),0) + (-9.054399e-06)*max(vdrp-(1.079911e+00),0)
                       + (-8.389836e-06)*max(vdrp-(1.104860e+00),0) + (-7.827816e-06)*max(vdrp-(1.130073e+00),0) + (-7.303472e-06)*max(vdrp-(1.155537e+00),0) + (-6.813635e-06)*max(vdrp-(1.181240e+00),0)
                       + (-6.355587e-06)*max(vdrp-(1.207171e+00),0) + (-5.927493e-06)*max(vdrp-(1.233317e+00),0) + (-5.526957e-06)*max(vdrp-(1.259666e+00),0) + (-5.152320e-06)*max(vdrp-(1.286210e+00),0)
                       + (-4.801791e-06)*max(vdrp-(1.312936e+00),0) + (-4.473643e-06)*max(vdrp-(1.339834e+00),0) + (-4.166440e-06)*max(vdrp-(1.366896e+00),0) + (-3.878773e-06)*max(vdrp-(1.394110e+00),0)
                       + (-3.609219e-06)*max(vdrp-(1.421470e+00),0) + (-3.356624e-06)*max(vdrp-(1.448965e+00),0) + (-3.119874e-06)*max(vdrp-(1.476587e+00),0) + (-2.897755e-06)*max(vdrp-(1.504329e+00),0)
                       + (-2.689412e-06)*max(vdrp-(1.532183e+00),0) + (-2.493867e-06)*max(vdrp-(1.560141e+00),0) + (-2.310225e-06)*max(vdrp-(1.588198e+00),0) + (-2.137759e-06)*max(vdrp-(1.616346e+00),0)
                       + (-1.975630e-06)*max(vdrp-(1.644578e+00),0) + (-1.823202e-06)*max(vdrp-(1.672890e+00),0) + (-1.679841e-06)*max(vdrp-(1.701275e+00),0) + (-1.544931e-06)*max(vdrp-(1.729727e+00),0)
                       + (-1.417870e-06)*max(vdrp-(1.758243e+00),0) + (-1.298190e-06)*max(vdrp-(1.786816e+00),0) + (-1.185452e-06)*max(vdrp-(1.815442e+00),0) + (-1.079098e-06)*max(vdrp-(1.844117e+00),0)
                       + (-9.786941e-07)*max(vdrp-(1.872836e+00),0) + (-8.844283e-07)*max(vdrp-(1.901596e+00),0) + (-7.945286e-07)*max(vdrp-(1.930392e+00),0) + (-7.103532e-07)*max(vdrp-(1.959221e+00),0)
                       + (-6.305246e-07)*max(vdrp-(1.988080e+00),0) + (-5.549568e-07)*max(vdrp-(2.016965e+00),0) + (-4.838124e-07)*max(vdrp-(2.045874e+00),0) + (-4.163064e-07)*max(vdrp-(2.074802e+00),0)
                       + (-3.521430e-07)*max(vdrp-(2.103748e+00),0) + (-2.915106e-07)*max(vdrp-(2.132709e+00),0) + (-2.343647e-07)*max(vdrp-(2.161682e+00),0) + (-1.797146e-07)*max(vdrp-(2.190665e+00),0)
                       + (-1.282423e-07)*max(vdrp-(2.219655e+00),0) + (-7.944350e-08)*max(vdrp-(2.248651e+00),0) + (-3.234301e-08)*max(vdrp-(2.277650e+00),0) + (1.117702e-08)*max(vdrp-(2.306650e+00),0)
                       + (5.351203e-08)*max(vdrp-(2.335650e+00),0) + (9.301177e-08)*max(vdrp-(2.364648e+00),0) + (1.313535e-07)*max(vdrp-(2.393642e+00),0) + (1.671196e-07)*max(vdrp-(2.422630e+00),0)
                       + (2.012699e-07)*max(vdrp-(2.451611e+00),0) + (2.342878e-07)*max(vdrp-(2.480584e+00),0) + (2.652254e-07)*max(vdrp-(2.509547e+00),0) + (2.945624e-07)*max(vdrp-(2.538499e+00),0)
                       + (3.230182e-07)*max(vdrp-(2.567438e+00),0) + (3.501178e-07)*max(vdrp-(2.596364e+00),0) + (3.751435e-07)*max(vdrp-(2.625276e+00),0) + (4.000102e-07)*max(vdrp-(2.654171e+00),0)
                       + (4.232818e-07)*max(vdrp-(2.683050e+00),0) + (4.454359e-07)*max(vdrp-(2.711912e+00),0) + (4.667115e-07)*max(vdrp-(2.740755e+00),0) + (4.871076e-07)*max(vdrp-(2.769578e+00),0)
                       + (5.061398e-07)*max(vdrp-(2.798381e+00),0) + (5.247701e-07)*max(vdrp-(2.827163e+00),0) + (5.425146e-07)*max(vdrp-(2.855924e+00),0) + (5.593701e-07)*max(vdrp-(2.884662e+00),0)
                       + (5.755760e-07)*max(vdrp-(2.913377e+00),0) + (5.908865e-07)*max(vdrp-(2.942068e+00),0) + (6.057850e-07)*max(vdrp-(2.970735e+00),0) + (6.197816e-07)*max(vdrp-(2.999377e+00),0)
                       + (6.331160e-07)*max(vdrp-(3.027994e+00),0) + (6.465199e-07)*max(vdrp-(3.056585e+00),0) + (6.585215e-07)*max(vdrp-(3.085149e+00),0) + (6.705875e-07)*max(vdrp-(3.113687e+00),0)
                       + (6.814865e-07)*max(vdrp-(3.142197e+00),0) + (6.929395e-07)*max(vdrp-(3.170680e+00),0) + (7.029712e-07)*max(vdrp-(3.199134e+00),0) + (7.130591e-07)*max(vdrp-(3.227561e+00),0)
                       + (7.224585e-07)*max(vdrp-(3.255958e+00),0) + (7.316624e-07)*max(vdrp-(3.284326e+00),0) + (7.406693e-07)*max(vdrp-(3.312665e+00),0) + (7.484778e-07)*max(vdrp-(3.340974e+00),0)
                       + (7.570829e-07)*max(vdrp-(3.369253e+00),0) + (7.644823e-07)*max(vdrp-(3.397502e+00),0) + (7.719245e-07)*max(vdrp-(3.425721e+00),0) + (7.791576e-07)*max(vdrp-(3.453908e+00),0)
                       + (7.856744e-07)*max(vdrp-(3.482065e+00),0) + (7.922288e-07)*max(vdrp-(3.510191e+00),0) + (7.985672e-07)*max(vdrp-(3.538285e+00),0) + (8.044333e-07)*max(vdrp-(3.566348e+00),0);
    end

    // ---- intrinsic output noise: decoupled Norton current @vout ----
    // white floor: R-only node nw (V PSD = 4kT*NRk) transconducted by gw
    I(nw, gnd)   <+ V(nw, gnd)/NRk;
    I(nw, gnd)   <+ white_noise(4*`P_K*$temperature/NRk, "nw");
    I(vout, gnd) <+ gnw*V(nw, gnd);
    // 6 Lorentzian sections: R||C node nk (corner fk) transconducted by g_k
    I(nk1, gnd) <+ V(nk1, gnd)/NRk + Cn1*ddt(V(nk1, gnd));
    I(nk1, gnd) <+ white_noise(4*`P_K*$temperature/NRk, "nk1");
    I(vout, gnd)    <+ gn1*V(nk1, gnd);
    I(nk2, gnd) <+ V(nk2, gnd)/NRk + Cn2*ddt(V(nk2, gnd));
    I(nk2, gnd) <+ white_noise(4*`P_K*$temperature/NRk, "nk2");
    I(vout, gnd)    <+ gn2*V(nk2, gnd);
    I(nk3, gnd) <+ V(nk3, gnd)/NRk + Cn3*ddt(V(nk3, gnd));
    I(nk3, gnd) <+ white_noise(4*`P_K*$temperature/NRk, "nk3");
    I(vout, gnd)    <+ gn3*V(nk3, gnd);
    I(nk4, gnd) <+ V(nk4, gnd)/NRk + Cn4*ddt(V(nk4, gnd));
    I(nk4, gnd) <+ white_noise(4*`P_K*$temperature/NRk, "nk4");
    I(vout, gnd)    <+ gn4*V(nk4, gnd);
    I(nk5, gnd) <+ V(nk5, gnd)/NRk + Cn5*ddt(V(nk5, gnd));
    I(nk5, gnd) <+ white_noise(4*`P_K*$temperature/NRk, "nk5");
    I(vout, gnd)    <+ gn5*V(nk5, gnd);
    I(nk6, gnd) <+ V(nk6, gnd)/NRk + Cn6*ddt(V(nk6, gnd));
    I(nk6, gnd) <+ white_noise(4*`P_K*$temperature/NRk, "nk6");
    I(vout, gnd)    <+ gn6*V(nk6, gnd);

    // ---- PSRR path: i_c = G0 + sum Gi*LP_i(vin-vdd) into vout (x Zout) ----
    // signed real-pole section bank (R_i = 1/(wi*Cps), so 1/R_i = wi*Cps)
    I(vin, np1) <+ V(vin, np1)*(w1*Cps);
    I(np1, vrf) <+ Cps*ddt(V(np1, vrf));
    I(vin, np2) <+ V(vin, np2)*(w2*Cps);
    I(np2, vrf) <+ Cps*ddt(V(np2, vrf));
    I(vin, np3) <+ V(vin, np3)*(w3*Cps);
    I(np3, vrf) <+ Cps*ddt(V(np3, vrf));
    // NEGATIVE sign so I(vout,gnd)<+ ... injects current INTO vout (matches the SPICE
    // 'G* gnd vout' source order / the .lib +H realization; same convention as spurs).
    I(vout, gnd) <+ -(G0*V(vin, vrf) + G1*V(np1, vrf)
                   + G2*V(np2, vrf) + G3*V(np3, vrf));

    // ---- PSRR complex-conjugate 2nd-order section (non-min-phase / notch phase) ----
    // series R-L-C lowpass state x=V(ncs2,vrf); b0 reads V_C=x, b1 reads V_R=a1*dx/dt.
    // i_c += (pcb0+pcb1 s)/(1+a1 s+a2 s^2)*(vin-vrf). Inert when pcb0=pcb1=0. No laplace.
    I(vin, ncs1)  <+ V(vin, ncs1)/Rpc;
    I(ncs1, ncs2) <+ idt(V(ncs1, ncs2))/Lpc;
    I(ncs2, vrf)  <+ Cpc*ddt(V(ncs2, vrf));
    I(vout, gnd)  <+ -(pcb0*V(ncs2, vrf) + gqb1*V(vin, ncs1));   // INTO vout (see bank above)

    // ---- intrinsic discrete spurs: deterministic current tones @vout ----
    I(vout, gnd) <+ -sa1*sin(`M_TWO_PI*9.999844e+05*$abstime + (-1.138283));
    I(vout, gnd) <+ -sa2*sin(`M_TWO_PI*2.499961e+06*$abstime + (2.862216));
    I(vout, gnd) <+ -sa3*sin(`M_TWO_PI*3.999938e+06*$abstime + (3.137809));
  end
endmodule
