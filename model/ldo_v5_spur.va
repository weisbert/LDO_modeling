// ============================================================
// Behavioral LDO model for Cadence Spectre  (auto-gen: harness/fit_model.py)
// Equivalent to model/ldo_model.lib (validated in ngspice). NO laplace_nd.
//   Zout = (R_a + sL_a||R_pl) || (R_b+sL_b) || (ESR+1/sCout) ; R_pl damps L
//   PSRR = i_c*Zout, i_c = G0 + sum Gi/(1+s/wi) [real bank] + one signed COMPLEX 2nd-
//          order section (b0+b1 s)/(1+s/(Q w0)+(s/w0)^2) -> non-min-phase / notch PHASE
//          (V4/V3). LP filter resistors are noiseless conductances (no thermal noise).
//   Noise= DECOUPLED Norton @vout: white-R + 6 R||C-Lorentzian current sections,
//          transconducted into vout (gm sets amplitude) -> In*|Zout| = Sv. pnoise/hbnoise.
//   slew_en=1 : nonlinear DC-curve branch (current-limit + dropout) via $table_model
// Params interpolated as quadratics in ln(iload) through corners {20u,121u,250u}.
// ============================================================
`include "constants.vams"
`include "disciplines.vams"

module ldo_model(vin, vout);
  inout vin, vout;
  electrical vin, vout, vrg, nA, nC, nbb, np1, np2, np3, vrf, ncs1, ncs2, nw, nk1, nk2, nk3, nk4, nk5, nk6;

  parameter real iload   = 1.210000e-04 from (0:inf);
  parameter integer slew_en = 0 from [0:1];
  parameter real Cout = 9.969315e-10;   // auto-extracted physical output cap
  parameter real ESR  = 5.000093e-01;   // auto-extracted physical ESR
  parameter real VREG121 = 9.011242e-01;
  parameter real NRk = 1.000000e+06;   // fixed noise-section resistor (gm sets amplitude)
  parameter real Cn1 = 8.588995e-09;   // corner 18.53 Hz
  parameter real Cn2 = 6.072694e-10;   // corner 262.1 Hz
  parameter real Cn3 = 4.191329e-11;   // corner 3797 Hz
  parameter real Cn4 = 4.053907e-13;   // corner 3.926e+05 Hz
  parameter real Cn5 = 2.027003e-13;   // corner 7.852e+05 Hz
  parameter real Cn6 = 2.090802e-15;   // corner 7.612e+07 Hz

  real u, ic, R_a, L_a, R_pl, R_b, L_b, G0, G1, w1, G2, w2, G3, w3, gnw, gn1, gn2, gn3, gn4, gn5, gn6, sa1, sa2, sa3, vreg, Cps;
  real pcb0, pcb1, pcw0, pcq, pca1, pca2, Rpc, Lpc, Cpc, gqb1;

  analog begin
    @(initial_step) begin
      ic = min(max(iload, 2.000000e-05), 2.500000e-04);
      u  = ln(ic);
      R_a = min(max(exp((1.836710e-01)*u*u + (2.900097e+00)*u + (1.429951e+01)),1.774208e+01),8.376544e+01);
      L_a = min(max(exp((1.396641e-01)*u*u + (2.061160e+00)*u + (-4.541689e+00)),5.936622e-06),2.787298e-05);
      R_pl = min(max(exp((2.332657e-13)*u*u + (4.518403e-12)*u + (2.072327e+01)),9.950249e+08),1.005000e+09);
      R_b = min(max(exp((1.392200e-16)*u*u + (4.129372e-15)*u + (2.072327e+01)),9.950249e+08),1.005000e+09);
      L_b = min(max(exp((6.069877e-16)*u*u + (6.085391e-15)*u + (-2.763102e+01)),9.950249e-13),1.005000e-12);
      G0 = min(max((1.955015e-04)*u*u + (4.609397e-03)*u + (2.746233e-02),4.655433e-04),2.691572e-03);
      G1 = min(max((4.386092e-05)*u*u + (2.757975e-04)*u + (-2.593843e-03),-1.871177e-03),-4.361133e-04);
      w1 = min(max(exp((3.844910e-02)*u*u + (7.335623e-01)*u + (1.840398e+01)),2.989163e+06),3.182342e+06);
      G2 = min(max((0.000000e+00)*u*u + (0.000000e+00)*u + (0.000000e+00),0.000000e+00),0.000000e+00);
      w2 = min(max(exp((1.392200e-16)*u*u + (4.129372e-15)*u + (2.072327e+01)),9.950249e+08),1.005000e+09);
      G3 = min(max((0.000000e+00)*u*u + (0.000000e+00)*u + (0.000000e+00),0.000000e+00),0.000000e+00);
      w3 = min(max(exp((1.392200e-16)*u*u + (4.129372e-15)*u + (2.072327e+01)),9.950249e+08),1.005000e+09);
      pcb0 = min(max((0.000000e+00)*u*u + (0.000000e+00)*u + (0.000000e+00),0.000000e+00),0.000000e+00);
      pcb1 = min(max((0.000000e+00)*u*u + (0.000000e+00)*u + (0.000000e+00),0.000000e+00),0.000000e+00);
      pcw0 = min(max(exp((4.717895e-16)*u*u + (1.054077e-14)*u + (1.219951e+01)),1.977032e+05),1.996852e+05);
      pcq = min(max(exp((0.000000e+00)*u*u + (0.000000e+00)*u + (0.000000e+00)),9.950249e-01),1.005000e+00);
      gnw = min(max(exp((-5.816257e-02)*u*u + (-1.163303e+00)*u + (-1.419655e+01)),1.927479e-04),2.217763e-04);
      gn1 = min(max(exp((-1.880571e-01)*u*u + (-2.987837e+00)*u + (-1.143675e+01)),3.232263e-01),1.511066e+00);
      gn2 = min(max(exp((-1.836635e-01)*u*u + (-2.904064e+00)*u + (-1.244267e+01)),7.986837e-02),3.731874e-01);
      gn3 = min(max(exp((-2.029024e-01)*u*u + (-3.270874e+00)*u + (-1.545121e+01)),2.194172e-02),1.027614e-01);
      gn4 = min(max(exp((-1.691179e-01)*u*u + (-2.625159e+00)*u + (-1.304568e+01)),1.173413e-02),5.495036e-02);
      gn5 = min(max(exp((2.098653e+00)*u*u + (3.828265e+01)*u + (1.616939e+02)),2.565785e-06),1.084506e-03);
      gn6 = min(max(exp((-8.941417e-02)*u*u + (-1.873140e+00)*u + (-2.762052e+01)),1.197424e-08),1.830523e-08);
      sa1 = min(max(exp((-1.441285e-01)*u*u + (-2.163043e+00)*u + (-1.987743e+01)),1.590365e-06),7.161181e-06);
      sa2 = min(max(exp((-1.552560e-01)*u*u + (-2.360956e+00)*u + (-2.223238e+01)),3.491402e-07),1.631908e-06);
      sa3 = min(max(exp((-2.317441e-03)*u*u + (-4.557877e-02)*u + (-1.224836e+01)),5.934466e-06),6.017734e-06);
      vreg = min(max((2.001640e-04)*u*u + (2.411893e-03)*u + (9.065944e-01),9.003417e-01),9.039489e-01);
      Cps = 1e-12;
      // complex PSRR section: a1=1/(Q.w0), a2=1/w0^2 ; series R-L-C (Cpc fixed)
      Cpc = 1e-12;
      pca1 = 1.0/(pcq*pcw0); pca2 = 1.0/(pcw0*pcw0);
      Rpc = pca1/Cpc; Lpc = pca2/Cpc; gqb1 = pcb1/pca1;
    end

    // ---- references / DC operating point ----
    V(vrf) <+ 1.05;                  // nominal-vin reference (no DC coupling)
    V(vrg) <+ vreg;                  // regulated output reference (vreg = real var)

    // ---- Zout branch C: series Cout + ESR (vout -> vrg) ----
    I(vout, nC) <+ Cout*ddt(V(vout, nC));
    V(nC, vrg)  <+ ESR*I(nC, vrg);

    // ---- Zout branch B: optional 2nd R-L (R_b->inf disables it) ----
    I(vout, nbb) <+ idt(V(vout, nbb))/L_b;
    V(nbb, vrg)  <+ R_b*I(nbb, vrg);

    // ---- Zout branch A: (L_a || R_pl) + (R_a | nonlinear dropout) ----
    // L_a||R_pl as summed current contributions (idt form admits the parallel R)
    I(vout, nA) <+ idt(V(vout, nA))/L_a + V(vout, nA)/R_pl;
    if (slew_en == 0)
      V(nA, vrg) <+ R_a*I(nA, vrg);
    else                             // $table_model control string may be Spectre-version specific
      I(vrg, nA) <+ $table_model(V(vrg, nA) - (vreg - VREG121), "ldo_v5_spur_dropout.tbl", "1L");

    // ---- intrinsic output noise: decoupled Norton current @vout ----
    // white floor: R-only node nw (V PSD = 4kT*NRk) transconducted by gw
    I(nw)   <+ V(nw)/NRk;
    I(nw)   <+ white_noise(4*`P_K*$temperature/NRk, "nw");
    I(vout) <+ gnw*V(nw);
    // 6 Lorentzian sections: R||C node nk (corner fk) transconducted by g_k
    I(nk1) <+ V(nk1)/NRk + Cn1*ddt(V(nk1));
    I(nk1) <+ white_noise(4*`P_K*$temperature/NRk, "nk1");
    I(vout)    <+ gn1*V(nk1);
    I(nk2) <+ V(nk2)/NRk + Cn2*ddt(V(nk2));
    I(nk2) <+ white_noise(4*`P_K*$temperature/NRk, "nk2");
    I(vout)    <+ gn2*V(nk2);
    I(nk3) <+ V(nk3)/NRk + Cn3*ddt(V(nk3));
    I(nk3) <+ white_noise(4*`P_K*$temperature/NRk, "nk3");
    I(vout)    <+ gn3*V(nk3);
    I(nk4) <+ V(nk4)/NRk + Cn4*ddt(V(nk4));
    I(nk4) <+ white_noise(4*`P_K*$temperature/NRk, "nk4");
    I(vout)    <+ gn4*V(nk4);
    I(nk5) <+ V(nk5)/NRk + Cn5*ddt(V(nk5));
    I(nk5) <+ white_noise(4*`P_K*$temperature/NRk, "nk5");
    I(vout)    <+ gn5*V(nk5);
    I(nk6) <+ V(nk6)/NRk + Cn6*ddt(V(nk6));
    I(nk6) <+ white_noise(4*`P_K*$temperature/NRk, "nk6");
    I(vout)    <+ gn6*V(nk6);

    // ---- PSRR path: i_c = G0 + sum Gi*LP_i(vin-1.05) into vout (x Zout) ----
    // signed real-pole section bank (R_i = 1/(wi*Cps), so 1/R_i = wi*Cps)
    I(vin, np1) <+ (V(vin) - V(np1))*(w1*Cps);
    I(np1, vrf) <+ Cps*ddt(V(np1, vrf));
    I(vin, np2) <+ (V(vin) - V(np2))*(w2*Cps);
    I(np2, vrf) <+ Cps*ddt(V(np2, vrf));
    I(vin, np3) <+ (V(vin) - V(np3))*(w3*Cps);
    I(np3, vrf) <+ Cps*ddt(V(np3, vrf));
    // NEGATIVE sign so I(vout)<+ ... injects current INTO vout (matches the SPICE
    // 'G* 0 vout' source order / the .lib +H realization; same convention as spurs).
    I(vout)     <+ -(G0*(V(vin) - V(vrf)) + G1*(V(np1) - V(vrf))
                   + G2*(V(np2) - V(vrf)) + G3*(V(np3) - V(vrf)));

    // ---- PSRR complex-conjugate 2nd-order section (non-min-phase / notch phase) ----
    // series R-L-C lowpass state x=V(ncs2,vrf); b0 reads V_C=x, b1 reads V_R=a1*dx/dt.
    // i_c += (pcb0+pcb1 s)/(1+a1 s+a2 s^2)*(vin-vrf). Inert when pcb0=pcb1=0. No laplace.
    I(vin, ncs1)  <+ V(vin, ncs1)/Rpc;
    I(ncs1, ncs2) <+ idt(V(ncs1, ncs2))/Lpc;
    I(ncs2, vrf)  <+ Cpc*ddt(V(ncs2, vrf));
    I(vout)       <+ -(pcb0*V(ncs2, vrf) + gqb1*V(vin, ncs1));   // INTO vout (see bank above)

    // ---- intrinsic discrete spurs: deterministic current tones @vout ----
    I(vout) <+ -sa1*sin(`M_TWO_PI*9.999844e+05*$abstime + (-1.138283));
    I(vout) <+ -sa2*sin(`M_TWO_PI*2.499961e+06*$abstime + (2.862216));
    I(vout) <+ -sa3*sin(`M_TWO_PI*3.999938e+06*$abstime + (3.137809));
  end
endmodule
